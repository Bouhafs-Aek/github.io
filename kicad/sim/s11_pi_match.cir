* SWRA117D 2.45 GHz antenna - input match of the pi network + antenna
*
* Mirrors the RF path of swra117d_2g4_antenna.kicad_sch:
*   J1 (50 ohm port) -- C1 shunt -- L1 series -- C2 shunt -- AE1
*
* With a 1 V AC source behind 50 ohm, the reflection coefficient seen at the
* connector is simply  gamma = 2*v(in) - 1,  because v(in) = Zin/(Zin+50).
*
* Run:   ngspice -b s11_pi_match.cir        (writes s11_results.csv)
* Tune:  edit the .param line; DNP parts are modelled as 1 fF / 1 pH.

.include antenna_swra117d.lib

.param c1=1f          $ C1 shunt, DNP by default
.param l1=0.8n        $ L1 series, fitted
.param c2=1f          $ C2 shunt, DNP by default

V1  src 0   dc 0 ac 1
Rs  src in  50
C1  in  0   {c1}
L1  in  ant {l1}
C2  ant 0   {c2}
XAE1 ant 0  ANT_SWRA117D_2G4

.control
  ac lin 2001 2.0e9 3.0e9
  let gamma = 2 * v(in) - 1
  let s11   = db(gamma)
  let rho   = mag(gamma)
  let vswr  = (1 + rho) / (1 - rho)
  let zin   = 50 * v(in) / (1 - v(in))
  let rin   = real(zin)
  let xin   = imag(zin)

  meas ac s11min  MIN s11 from=2.0e9 to=3.0e9
  meas ac fres    WHEN s11=s11min FALL=1
  meas ac s11_2g4 FIND s11 AT=2.44e9
  meas ac vswr2g4 FIND vswr AT=2.44e9

  echo "--- input match ---"
  print s11min fres s11_2g4 vswr2g4

  wrdata s11_results.csv s11 vswr rin xin
  if $?batchmode = 0
    plot s11 xlabel "frequency [Hz]" ylabel "S11 [dB]"
    plot rin xin xlabel "frequency [Hz]" ylabel "Zin [ohm]"
  end
.endc
.end
